module CELL(in,out,ocv,current,soc);

inout  in,out;
input  current;
output soc,ocv;

electrical in, out, ocv, current, soc;

parameter integer RESET   = 0           alterable;
parameter real SOC_0      = 1		alterable;
parameter real ETA_CHARGE = 0.99	alterable;
parameter real Q_NOM      = 1		alterable;
parameter real R_INT      = 8m		alterable;

real ETA;
real R0;
real R1;

integer Reset;

analog begin

    if (v(current) > 0)
	ETA = ETA_CHARGE;
    else
        ETA = 1;

    if( analysis("dc") )
        Reset = 1;
    else
        Reset = 0 + RESET;

    v(soc)    <+ idt(v(current)*ETA/(Q_NOM*3600),SOC_0,Reset);
    v(ocv)    <+ $table_model("CCC", v(soc)*100, "SOC", "OCV");
//    v(ocv)    <+ 4;

//    R0        =  $table_model("CCC", v(soc)*100, "SOC", "R0");
//    R1        =  $table_model("CCC", v(soc)*100, "SOC", "R1");

    v(in,out) <+ v(ocv) + (R_INT)*v(current);
//    v(in,out) <+ v(ocv) + (R0+R1)*v(current);

// v(in,out) <+ v(ocv) + (8m)*v(current);

end

endmodule
