module DCDC_CONTROL(p_ref,CP_signal,v_cell,soc,status_CP,status_CC,status_CV);

input  p_ref,CP_signal,v_cell,soc;
output status_CP,status_CC,status_CV;

electrical p_ref,CP_signal,v_cell,soc,status_CP,status_CC,status_CV;

parameter real V_THRESHOLD  	= 4	alterable;
parameter real SOC_THRESHOLD  	= 0.8	alterable;
parameter real I_NOM        	= 10	alterable;
parameter real R_INT        	= 1m	alterable;

real    T_RESET;
integer STATUS;

// STATUS = 0 (CC)
// STATUS = 1 (CV)
// STATUS = 2 (CP)

analog begin
// -----------------------------------------------
// TASKS TO BE EXECUTED AT THE VERY BEGINNING
// -----------------------------------------------

	// QUESTO BLOCCO MI SERVE ALTRIMENTI PARTO DA UNA CONDIZIONE DIVERSA!
	if(analysis("dc")) begin
	    if (v(CP_signal) ==1) begin
	    	STATUS = 2;
    		end else begin
		STATUS = 0;
	    end
	    T_RESET = 0;
	end

	@(initial_model) begin
	    if (v(CP_signal) ==1) begin
	    	STATUS = 2;
    		end else begin
		STATUS = 0;
	    end
	    T_RESET = 0;
	end

// -----------------------------------------------
// TASKS TO BE EXECUTED DURING SIMULATION
// -----------------------------------------------

if ($abstime > 100) begin
// 	if (STATUS != 1 && v(p_ref) >0) begin
	     if (STATUS != 1) begin
//		if (v(soc) > SOC_THRESHOLD) begin
		if (v(v_cell) > V_THRESHOLD) begin
			STATUS = 1;
		end
        end
end

	if (STATUS == 0) begin
   		v(status_CC) <+ 1;
   		v(status_CV) <+ 0;
   		v(status_CP) <+ 0;
   	end else if (STATUS == 1) begin
 		v(status_CC) <+ 0;
   		v(status_CV) <+ 1;
   		v(status_CP) <+ 0;
  	 end else if( STATUS == 2 ) begin
 		v(status_CC) <+ 0;
   		v(status_CV) <+ 0;
   		v(status_CP) <+ 1;
    	end else
        	$finish();

end

endmodule
