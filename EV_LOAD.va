module EV_LOAD(vd,vq,prec);

input 		vd,vq;
output          prec;
electrical 	vd,vq;
electrical      prec;

parameter real    S_NOM     = 50k               alterable;
parameter real    V_NOM     = 400               alterable;
parameter real    V_MIN     = V_NOM*0.2/sqrt(2) alterable;
parameter real    V_MAX     = V_NOM*1.8/sqrt(2) alterable;

// PARAMETERS OF THE STATIC LOAD MODEL
parameter real    SOC_0     = 0.1               alterable;
parameter integer CP_SIGNAL = 1                 alterable;
parameter real    ap        = 1                 alterable;
parameter real    bp        = 0.001		alterable;
parameter real    np        = -2		alterable;
parameter real    cp        = 0.9		alterable;
parameter real    dp        = 0.003		alterable;
parameter real    ep        = 0.09		alterable;
parameter real    fp        = 0.35		alterable;

// ----------------------------- //
// DYNAMIC LOAD MODEL PARAMETERS //
// ----------------------------- //
// PARAMETERS OF THE ERLM
parameter real    tau      =  0.01              alterable;

/*
// PARAMETERS OF THE VFLM (2ND ORDER)
// VF Parameters KI=1000
parameter real    A       =  47.81              alterable;
parameter real    B       =  1957             alterable;
parameter real    C       =  45.33            alterable;
parameter real    D       =  1961              alterable;
parameter real    ns       =  -0.0019           alterable;
parameter real    nt       =  1                 alterable;
electrical      x1;
electrical      x2;
*/

/*
// PARAMETERS OF THE VFLM (2ND ORDER)
// VF Parameters KI=100
parameter real    A       =  4.701              alterable;
parameter real    B       =  204.2             alterable;
parameter real    C       =  2.732            alterable;
parameter real    D       =  205.2              alterable;
parameter real    ns       =  -0.0019           alterable;
parameter real    nt       =  1                 alterable;
electrical      x1;
electrical      x2;
*/

// PARAMETERS OF THE VFLM (2ND ORDER)
// VF Parameters KI=80
parameter real    A       =  3.778              alterable;
parameter real    B       =  164             alterable;
parameter real    C       =  1.792            alterable;
parameter real    D       =  164.2              alterable;
parameter real    ns       =  -0.0019           alterable;
parameter real    nt       =  1                 alterable;
electrical      x1;
electrical      x2;

// GENERIC VARIABLES
real            PREF1;
real            PREF2;
real            PREF;
real            QREF;
real            VC;
real            V0;
real            P0;
real            Q0;
real            P_ING;
real            P_REC;
real            P_DYN;
real            Q_DYN;

analog begin

	if(analysis("dc")) begin
		VC    = sqrt(v(vd)*v(vd) + v(vq)*v(vq));
		PREF1 = S_NOM*(bp*pow(max(min(VC/V_NOM,1.2),0.8),np) +
			cp - dp*(1-SOC_0)/SOC_0 + ep*exp(-fp*(1-SOC_0)));

		PREF2 = S_NOM*(ap + bp*pow(max(min(VC/V_NOM,1.2),0.8),np));
		PREF  = PREF1*(1-CP_SIGNAL) + PREF2*CP_SIGNAL;
		QREF  = 0;

		P0 = PREF;
		Q0 = QREF;
		V0 = VC;

		i(vd) <+ (v(vd)*PREF + v(vq)*QREF)/(max(V_MIN*V_MIN,v(vd)*v(vd) + v(vq)*v(vq)));
		i(vq) <+ (v(vq)*PREF - v(vd)*QREF)/(max(V_MIN*V_MIN,v(vd)*v(vd) + v(vq)*v(vq)));
	v(prec) <+ 0;

	end else begin

	VC    = sqrt(v(vd)*v(vd) + v(vq)*v(vq));
	P_ING = pow(VC/V0,ns) - pow(VC/V0,nt);

	// ERLM
	//i(x1) <+ v(x1) + tau*ddt(v(x1)) - P_ING;
	//P_REC = v(x1);

/*
	// VFLM (4TH ORDER)
	i(x1) <+ ddt(v(x1)) - v(x2);
	i(x2) <+ ddt(v(x2)) - v(x3);
	i(x3) <+ ddt(v(x3)) - v(x4);
	i(x4) <+ ddt(v(x4)) + E*ddt(v(x3)) + F*ddt(v(x2)) + G*ddt(v(x1)) + H*v(x1) - A*ddt(ddt(ddt(P_ING))) - B*ddt(ddt(P_ING)) - C*ddt(P_ING) - D*P_ING;
	P_REC = v(x1);
*/

/*
	// VFLM (3RD ORDER)
	i(x1) <+ ddt(v(x1)) - v(x2);
	i(x2) <+ ddt(v(x2)) - v(x3);
	i(x3) <+ ddt(v(x3)) + D*ddt(v(x2)) + E*ddt(v(x1)) + F*v(x1) - A*ddt(ddt(P_ING)) - B*ddt(P_ING) - C*P_ING;
	P_REC = v(x1);
*/

	// VFLM (2ND ORDER)
	i(x1) <+ ddt(v(x1)) - v(x2);
	i(x2) <+ ddt(v(x2)) +  C*ddt(v(x1)) + D*v(x1) - A*ddt(P_ING) - B*P_ING;
	P_REC = v(x1);

	v(prec) <+ v(x1);
	P_DYN = P0*(P_REC + pow(VC/V0,nt));

	i(vd) <+ (v(vd)*P_DYN + v(vq)*Q0)/(max(V_MIN*V_MIN,v(vd)*v(vd) + v(vq)*v(vq)));
	i(vq) <+ (v(vq)*P_DYN - v(vd)*Q0)/(max(V_MIN*V_MIN,v(vd)*v(vd) + v(vq)*v(vq)));

	end

end

endmodule
