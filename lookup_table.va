module LOOKUP_TABLE(in,out);
input   in;
output out;

electrical in, out;

analog begin

    v(out) <+ $table_model("CCC", v(in), "InVec", "OutVec");

end

endmodule
